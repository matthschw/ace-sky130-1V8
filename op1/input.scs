// characterization single-ended opamp 'op1' in SkyWater 130nm 1V8

simulator lang=spectre
global 0

include "./models/sky130.scs" section=tt

parameters vs=100m vi=0 vsup=1.8 vcm=0 vo=0 vid=0 vicm=0            \
           a0=1 cl=5p fin=1k i0=3u rl=100M                          \
           Lcm1=0.4 Lcm2=0.4 Lcs=0.4 Ld=0.4 Lres=99.0               \
           Wcm1=3.0 Wcm2=3.0 Wcs=3.0 Wd=3.0 Wres=2.0   Wcap=69.0    \
           Mcm11=1  Mcm21=2  Mcs=22  Md=2              Mcap=1       \
           Mcm12=5  Mcm22=2                                         \
           Mcm13=22                                                 \
           A=(Mcm13+Mcm12+Mcm13)*Wcm1*Lcm1+2*Md*Wd*Ld+              \
             (Mcm21+Mcm22)*Wcm2*Lcm2+Mcs*Wcs*Lcs+Wres*Lres+         \
             Wcap*Wcap*Mcap

subckt ideal_balun d c p n
    K0 (d 0 p c) transformer n1=2
    K1 (d 0 c n) transformer n1=2
ends ideal_balun

// Biasing
VSUPP (VDD CM) vsource dc=vsup/2 type=dc
VSUPN (CM VSS) vsource dc=vsup/2 type=dc
IREF  (VDD B)  isource dc=i0 type=dc
VCM   (CM 0)   vsource type=dc dc=0

//DUT
DUT (B INP INN OUT VDD VSS) op

OUTIDEAL (OUT_IDEAL 0  INP 0) vcvs gain=1/a0

INPSW (INP ICLPULSE ICLSIN INPOL) switch position=1
INNSW (INN FBB             INNOL) switch position=1
OUTSW (OF  OFL  OUT)              switch position=1

IPRB0 (FBA FBB) iprobe
FBNET (FBA CM  OUT CM) vcvs gain=a0

VIPULSE (ICLPULSE CM) vsource type=pulse dc=vid val0=-vs/2  \
                      val1=vs/2 period=100u delay=5u rise=1n
VISIN   (ICLSIN   CM) vsource type=sine  ampl=a0 freq=fin

CL (OUT CM) capacitor c=cl
RL (OUT CM) resistor  r=rl

VO (OFI CM) vsource dc=vo type=dc
L2 (OFI OF) dcfeed l=1u
R2 (OFL  CM) resistor r=1M

BALUN (IND INCM INPOL INNOL) ideal_balun

VID  (IND  CM) vsource type=dc dc=vid mag=1
VICM (INCM CM) vsource type=dc dc=vicm

// 'op1' in XH035-3V3 as subckt
subckt op B INP INN O VDD VSS
    //biasing current mirror
    MNCM11  (B  B   VSS VSS) sky130_fd_pr__nfet_01v8 m=Mcm11 w=Wcm1 l=Lcm1
    MNCM12  (CM B   VSS VSS) sky130_fd_pr__nfet_01v8 m=Mcm12 w=Wcm1 l=Lcm1
    MNCM13  (O  B   VSS VSS) sky130_fd_pr__nfet_01v8 m=Mcm13 w=Wcm1 l=Lcm1

    //diffpair
    MND11   (Y  INP CM  VSS) sky130_fd_pr__nfet_01v8 m=Md w=Wd l=Ld
    MND12   (X  INN CM  VSS) sky130_fd_pr__nfet_01v8 m=Md w=Wd l=Ld

    //load for diffpair
    MPCM21  (X  X   VDD VDD) sky130_fd_pr__pfet_01v8 m=Mcm21 w=Wcm2 l=Lcm2
    MPCM22  (Y  X   VDD VDD) sky130_fd_pr__pfet_01v8 m=Mcm22 w=Wcm2 l=Lcm2

    MPCS    (O  Y   VDD VDD) sky130_fd_pr__pfet_01v8 m=Mcs w=Wcs l=Lcs

    //compensation network
    //C0      (O  A   VSS) cpp area=Wcap*Wcap peri=4*Wcap m=Mcap
    //R0      (A  Y   VSS) rp2 w=Wres l=Lres m=1
    CL (OUT CM) capacitor c=2p
    RL (OUT CM) resistor  r=2k
ends op

simulatorOptions options reltol=100e-6 vabstol=1e-6 iabstol=1e-12 temp=27      \
                         tnom=27 homotopy=all gmin=1e-12 rforce=1              \
                         save=selected dc_pivot_check=yes scale=1u

save DUT.M*.m*:gm   DUT.M*.m*:gds   DUT.M*.m*:id  DUT.M*.m*:gmoverid           \
     DUT.M*.m*:fug  DUT.M*.m*:vdsat DUT.M*.m*:vgs DUT.M*.m*:vds                \
     DUT.M*.m*:vbs  DUT.M*.m*:gmb   DUT.M*.m*:vth DUT.M*.m*:self_gain          \
     DUT.X          DUT.Y           DUT.B         DUT.CM                       \
     DUT:VDD        DUT:VSS         VDD           VSS                          \
     OUT            DUT:O           OUT           OUT_IDEAL                    \
     INN            INP

fb1 alter dev=INPSW param=position value=1
fb2 alter dev=INNSW param=position value=1
fb3 alter dev=OUTSW param=position value=1
fb4 alter param=vid value=0
fb5 alter param=vo value=0
fb6 alter param=a0 value=1

dcop dc save=selected title="dcop"
dcmatch (OUT CM) dcmatch mth=0.9 method=statistics nsigma=1        \
                 title="dcmatch" variations=mismatch where=rawfile \
                 prevoppoint=yes
stb stb start=1 stop=100G probe=IPRB0 localgnd=0 dec=50 title="stb"
tran tran stop=100u errpreset=conservative title="tran"
noise (OUT CM) noise start=1e-3 stop=1G iprobe=VIPULSE             \
    separatenoise=no save=selected title="noise"

fb7 alter param=a0 value=0.1
dc1 dc param=vid start=-vsup*0.1 stop=vsup*0.1 lin=500 title="dc1"

ol1 alter dev=INNSW param=position value=2
ol2 alter dev=INPSW param=position value=3
ol3 alter dev=OUTSW param=position value=2

xf (OUT CM) xf  start=1e-3 stop=1G dec=50 title="xf" annotate=no
ac ac freq=1 param=vicm start=-vsup stop=vsup lin=1500 title="ac" annotate=no

ol41 alter param=vid value=vs/2
ol42 alter param=vo value=-vsup/2
dc3 dc title="dc3" title="short-l"

ol51 alter param=vid value=-vs/2
ol52 alter param=vo value=vsup/2
dc4 dc title="dc4" title="short-h"
